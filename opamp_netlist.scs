// Design: opamp/opamp_1
simulator lang=spectre
global 0
include "/home/TSMC180/IC6/TSMC180/tsmc18/../models/spectre/cr018gpii_v1d0.scs" section=tt_rfres_sa
include "/home/TSMC180/IC6/TSMC180/tsmc18/../models/spectre/cr018gpii_v1d0.scs" section=tt_rfmvar
include "/home/TSMC180/IC6/TSMC180/tsmc18/../models/spectre/cr018gpii_v1d0.scs" section=tt_rtmom
include "/home/TSMC180/IC6/TSMC180/tsmc18/../models/spectre/cr018gpii_v1d0.scs" section=tt_disres
include "/home/TSMC180/IC6/TSMC180/tsmc18/../models/spectre/cr018gpii_v1d0.scs" section=tt
include "/home/TSMC180/IC6/TSMC180/tsmc18/../models/spectre/cr018gpii_v1d0.scs" section=tt_rfesd
include "/home/TSMC180/IC6/TSMC180/tsmc18/../models/spectre/cr018gpii_v1d0.scs" section=tt_mim
include "/home/TSMC180/IC6/TSMC180/tsmc18/../models/spectre/cr018gpii_v1d0.scs" section=tt_fmom
include "/home/TSMC180/IC6/TSMC180/tsmc18/../models/spectre/cr018gpii_v1d0.scs" section=tt_rfres_rpo
include "/home/TSMC180/IC6/TSMC180/tsmc18/../models/spectre/cr018gpii_v1d0.scs" section=tt_m
include "/home/TSMC180/IC6/TSMC180/tsmc18/../models/spectre/cr018gpii_v1d0.scs" section=tt_rfmim
include "/home/TSMC180/IC6/TSMC180/tsmc18/../models/spectre/cr018gpii_v1d0.scs" section=tt_res
include "/home/TSMC180/IC6/TSMC180/tsmc18/../models/spectre/cr018gpii_v1d0.scs" section=tt_bip
include "/home/TSMC180/IC6/TSMC180/tsmc18/../models/spectre/cr018gpii_v1d0.scs" section=tt_bip3
include "/home/TSMC180/IC6/TSMC180/tsmc18/../models/spectre/cr018gpii_v1d0.scs" section=tt_dio3
include "/home/TSMC180/IC6/TSMC180/tsmc18/../models/spectre/cr018gpii_v1d0.scs" section=tt_3v
include "/home/TSMC180/IC6/TSMC180/tsmc18/../models/spectre/cr018gpii_v1d0.scs" section=tt_na
include "/home/TSMC180/IC6/TSMC180/tsmc18/../models/spectre/cr018gpii_v1d0.scs" section=tt_dio
include "/home/TSMC180/IC6/TSMC180/tsmc18/../models/spectre/cr018gpii_v1d0.scs" section=tt_dio_m
include "/home/TSMC180/IC6/TSMC180/tsmc18/../models/spectre/cr018gpii_v1d0.scs" section=tt_rfind
include "/home/TSMC180/IC6/TSMC180/tsmc18/../models/spectre/cr018gpii_v1d0.scs" section=tt_dio_3m
include "/home/TSMC180/IC6/TSMC180/tsmc18/../models/spectre/cr018gpii_v1d0.scs" section=tt_bbmvar
include "/home/TSMC180/IC6/TSMC180/tsmc18/../models/spectre/cr018gpii_v1d0.scs" section=tt_rfres_hri
include "/home/TSMC180/IC6/TSMC180/tsmc18/../models/spectre/cr018gpii_v1d0.scs" section=tt_3vna
include "/home/TSMC180/IC6/TSMC180/tsmc18/../models/spectre/cr018gpii_v1d0.scs" section=tt_dio_dnw
include "/home/TSMC180/IC6/TSMC180/tsmc18/../models/spectre/cr018gpii_v1d0.scs" section=tt_3m
include "/home/TSMC180/IC6/TSMC180/tsmc18/../models/spectre/cr018gpii_v1d0.scs" section=tt_rfjvar
include "/home/TSMC180/IC6/TSMC180/tsmc18/../models/spectre/cr018gpii_v1d0.scs" section=tt_rfmos
include "/home/TSMC180/IC6/TSMC180/tsmc18/../models/spectre/cr018gpii_v1d0.scs" section=tt_rfsbd
include "/home/TSMC180/IC6/TSMC180/tsmc18/../models/spectre/cr018gpii_v1d0.scs" section=tt_rfmvar_33
include "/home/TSMC180/IC6/TSMC180/tsmc18/../models/spectre/cr018gpii_v1d0.scs" section=tt_rfmos33
include "/home/TSMC180/IC6/TSMC180/tsmc18/../models/spectre/cr018gpii_v1d0.scs" section=tt_rffmom
include "/home/TSMC180/IC6/TSMC180/tsmc18/../models/spectre/cr018gpii_v1d0.scs" section=stat_noise

// opamp/opamp_1/schematic
M6 (net8 net3 net1 net1) pch l=500n w=104.3u m=1 nf=10
M1 (net2 net2 net1 net1) pch l=1u w=39.52u m=1 nf=8
M0 (net3 net2 net1 net1) pch l=1u w=39.52u m=1 nf=8
M7 (net8 net5 0 0) nch l=1u w=48.06u m=1 nf=18
M5 (net5 net5 0 0) nch l=1u w=5.22u m=1 nf=2
M4 (net4 net5 0 0) nch l=1u w=20.88u m=1 nf=8
M3 (net3 net6 net4 0) nch l=500n w=6.42u m=1 nf=2
M2 (net2 net7 net4 0) nch l=500n w=6.42u m=1 nf=2
V2 (net6 0) vsource dc=900.0m mag=500m phase=0 type=dc
V1 (net7 0) vsource dc=900.0m mag=500m phase=180 type=dc
V0 (net1 0) vsource dc=1.8 type=dc
I3 (net1 net5) isource dc=10u type=dc
C2 (net8 0) capacitor c=10p
R0 (net9 net8 ) rppo1rpo l=27.47u w=2u mf=(1) m=1 mismatchflag=1

C0 (net3 net9) mimcap_2p0_sin lt=10u wt=10u mf=10 mismatchflag=1
simulatorOptions options temp=27
